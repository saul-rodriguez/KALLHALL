printf("KALLHALL libInit.il file is loaded\n")
;;load("./skill/test.il")

printf("initializing MOS callbacks\n");
load("./PCELL_KAL3_DEV/skill/kallhall_mos_l.cb");
load("./PCELL_KAL3_DEV/skill/kallhall_mos_w.cb");
;;load("./PCELL_KAL3_DEV/skill/kallhall_mos_wfinger.cb");
