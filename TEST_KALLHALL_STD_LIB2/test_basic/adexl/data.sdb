ADE simulation setup
Run mode: Single Run, Sweeps and Corners
Tests:
  TEST_KALLHALL_STD_LIB2:test_basic:1: TEST_KALLHALL_STD_LIB2/test_basic/config, simulator ams
