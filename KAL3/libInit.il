printf("KALLHALL libInit.il file is loaded\n")
;;load("./skill/test.il")

printf("initializing MOS callbacks\n");
load("./KAL3/skill/kallhall_mos_l.cb");
load("./KAL3/skill/kallhall_mos_w.cb");
